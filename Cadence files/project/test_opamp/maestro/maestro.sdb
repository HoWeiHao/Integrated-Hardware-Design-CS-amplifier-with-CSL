ADE simulation setup
Run mode: Single Run, Sweeps and Corners
Tests:
  project_test_opamp_1: project/test_opamp/schematic, simulator spectre
