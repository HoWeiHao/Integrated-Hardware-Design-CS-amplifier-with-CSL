ADE simulation setup
Test project_test_opamp_1: project/test_opamp/schematic, simulator spectre
  Models: /app11/gpdk180_v3.3/models/spectre/gpdk.scs[NN]
  Temperature: 27
  Analysis stb: start=10k stop=1G probe=/IPRB0 stbProbeMode=single-ended
Run mode: Single Run, Sweeps and Corners
