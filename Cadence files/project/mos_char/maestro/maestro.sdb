ADE simulation setup
Run mode: Single Run, Sweeps and Corners
Tests:
  project_mos_char_1: project/mos_char/schematic, simulator spectre
Corners (nominal off):
  model folders: /app11/gpdk180_v3.3/models/spectre
  C0: gpdk.scs[FF FS NN SF SS]
