ADE simulation setup
Test project_mos_char_1: project/mos_char/schematic, simulator spectre
  Models: /app11/gpdk180_v3.3/models/spectre/gpdk.scs[NN]
  Temperature: 27
  Analysis dc: sweep /V0.dc start=0 stop=1.8 step=0.05
  Signals: /NM1/D (terminal), /NM1/S (terminal), /NM1/G (terminal), /NM1/B (terminal)
Run mode: Single Run, Sweeps and Corners
Corners (nominal off):
  model folders: /app11/gpdk180_v3.3/models/spectre
  C0: gpdk.scs[FF FS NN SF SS]
