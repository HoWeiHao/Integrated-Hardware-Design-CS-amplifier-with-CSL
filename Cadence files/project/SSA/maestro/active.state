ADE simulation setup
Test project_SSA_1: project/SSA/schematic, simulator spectre
  Models: /app11/gpdk180_v3.3/models/spectre/gpdk.scs[NN]
  Temperature: 27
  Analysis tran: stop=50u
  Signals: /net6, /net2
Run mode: Single Run, Sweeps and Corners
