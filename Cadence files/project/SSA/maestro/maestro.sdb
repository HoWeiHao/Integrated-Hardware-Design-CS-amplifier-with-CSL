ADE simulation setup
Run mode: Single Run, Sweeps and Corners
Tests:
  project_SSA_1: project/SSA/schematic, simulator spectre
